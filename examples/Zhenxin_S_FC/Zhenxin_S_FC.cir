*Zhenxin_S_FC

.include "/home/pham/code/analog-ml/AutoCkt/eval_engines/ngspice/ngspice_inputs/spice_models/65nm_bulk.txt"

* Parameters
.param tempc=25.0
.param wm12=28u lm12=400n mm12=1
.param wm3=30u lm3=400n mm3=1
.param wm45=6u lm45=600n mm45=1
.param wm67=6u lm67=600n mm67=1
.param wm89=5u lm89=600n mm89=1
.param wm1011=18u lm1011=600n mm1011=1

.param vbp1=0.89
.param vbp2=0.715
.param vbn1=0.505
.param vbn2=0.295

.param vdd=1.2
.param vcm=0.6

M3 N004 Vbp1 Vdd Vdd pmos W={wm3} L={lm3} m={mm3}
M4 N002 N001 Vdd Vdd pmos W={wm45} L={lm45} m={mm45}
M5 N003 N001 Vdd Vdd pmos W={wm45} L={lm45} m={mm45}
M7 Vout Vbp2 N003 N003 pmos W={wm67} L={lm67} m={mm67}
M6 N001 Vbp2 N002 N002 pmos W={wm67} L={lm67} m={mm67}
M1 N006 Vinp N004 N004 pmos W={wm12} L={lm12} m={mm12}
M2 N005 Vinn N004 N004 pmos W={wm12} L={lm12} m={mm12}
M8 N001 Vbn1 N006 N006 nmos W={wm89} L={lm89} m={mm89}
M9 Vout Vbn1 N005 N005 nmos W={wm89} L={lm89} m={mm89}
M10 N006 Vbn2 0 0 nmos W={wm1011} L={lm1011} m={mm1011}
M11 N005 Vbn2 0 0 nmos W={wm1011} L={lm1011} m={mm1011}

Ccomp N001 Vout 1p
Cload Vout 0 1p

* Voltage sources
* VS gnd 0 DC 0
V0 vdd 0 DC {vdd}
V2 in 0 DC 0 AC 1
E1 Vinp cm in 0 0.5
E0 Vinn cm in 0 -0.5
V1 cm 0 DC {vcm}
VP2 Vbp1 0 DC {vbp1}
VN Vbp2 0 DC {vbp2}
VN1 Vbn1 0 DC {vbn1}
VN2 Vbn2 0 DC {vbn2}

.control
op
set xbrushwidth=3
set filetype=ascii
run

ac dec 10 1 100G
run
set units=degrees
set wr_vecnames
option numdgt=7
wrdata ac.csv v(Vout)

meas ac gain_bandwidth_product_ when vdb(Vout)=0
meas ac phase_margin find vp(Vout) when vdb(Vout)=0
wrdata GBW_PM gain_bandwidth_product_ phase_margin

op
wrdata dc.csv i(V0)
quit
.endc

.end
